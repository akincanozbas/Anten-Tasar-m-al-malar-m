# Ansys Electronics Desktop project, version 2022.1
materials:
  vacuum: permittivity=1
  copper: permeability=0.999991 conductivity=58000000
  Rogers RT/duroid 5880 (tm): permittivity=2.2 dielectric_loss_tangent=0.0009

design HFSSDesign1 (HFSS, DrivenModal, model units mm)
variables:
  s = 0.015mm
  rate = 33.85
  h = 0.508mm
  TL = 200mm
  cThick = 0.035mm
  W = 120mm
  L = 240mm
  MW = 1.78mm
geometry:
  EquationSurface1 = equation_based_surface(XuvFunction=_u YuvFunction=s*_v*exp(_u*rate) ZuvFunction=h uStart=36.9mm uEnd=TL+40mm vStart=-1 vEnd=1)
  Circle1 = circle(normal=Z, centre=(19mm, 0mm, h), radius=18mm)
  Circle1.unite(EquationSurface1)
  Circle1.thicken(cThick)
  substrate [Rogers RT/duroid 5880 (tm)] = box(corner=(0mm, -W/2, 0mm), size=(L, W, h))
  vivaldi_antenna [copper] = rectangle(corner=(0mm, -W/2, h), x_size=L, y_size=W)
  vivaldi_antenna.thicken(cThick)
  vivaldi_antenna.subtract(Circle1)
  feed_line [copper] = rectangle(corner=(37mm, -W/2, -cThick), x_size=MW, y_size=W/2)
  Polyline1 = polyline(z=-cThick, xy in mm: (45.5, 9) (52.5, 9) (45.5, 16) (45.5, 9), closed, covered)
  Polyline2 = polyline(z=-cThick, xy in mm: (45.5, 16) (51, 13.3) (52.5, 9) (45.5, 16), closed, covered, Arc from point 0 over 3)
  Polyline1.unite(Polyline2)
  Polyline1.rotate(axis=Z, angle=10deg)
  Polyline1.move(-6.2mm, -17.7mm, 0mm)
  feed_line.unite(Polyline1)
  feed_line.thicken(cThick)
  port = rectangle(corner=(37mm, -60mm, -cThick), z_size=0.578mm, x_size=MW)
  RadiatingSurface [vacuum] = region(absolute_offset=50mm on all sides)
boundaries and excitations:
  Open1: Radiation Objects=RadiatingSurface
  1: Lumped Port Objects=port Modes{Mode1{IntLine{(37.89, -60, -0.035) -> (37.89, -60, 0.543)} CharImp=Zpi RenormImp=50ohm}} Impedance=50ohm
setups:
  Setup1: HfssDriven MultipleAdaptiveFreqsSetup{Low=2GHz High=20GHz} MaxDeltaS=0.05 MaximumPasses=10 MinimumPasses=1 MinimumConvergedPasses=1 PercentRefinement=30 BasisOrder=1 PortAccuracy=2 DrivenSolverType="Direct Solver"
    sweep Sweep: 1GHz to 20GHz, 200 points; Type=Fast SaveFields
source amplitudes:
  1:1: 1W 0deg
radiation setups:
  3D: Infinite Sphere Theta=0deg..180deg step 2deg Phi=-180deg..180deg step 2deg
  Elevation: Infinite Sphere Theta=-180deg..180deg step 1deg Phi=0deg..90deg step 90deg
  Azimuth: Infinite Sphere Theta=90deg..90deg step 0deg Phi=-180deg..180deg step 1deg
  Infinite Sphere1: Infinite Sphere Theta=-180deg..180deg step 10deg Phi=0deg..360deg step 10deg
reports:
  S Parameter Plot 1: dB(S(1,1)) vs Freq on Setup1 : Sweep; markers m1 at 15.60804GHz, m2 at 12.170854GHz
  Gain Plot 1: dB(GainTotal) vs Phi, Theta on Setup1 : LastAdaptive, Infinite Sphere1 [Freq=11GHz]
  Gain Plot 2: GainTotal vs Theta on Setup1 : LastAdaptive, Infinite Sphere1 [Phi=0deg Freq=11GHz]; markers m1 at 90deg
  S Parameter Plot 2: dB(S(1,1)) vs Freq on Setup1 : Sweep
