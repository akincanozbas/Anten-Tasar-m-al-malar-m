# Ansys Electronics Desktop project, version 2022.1
materials:
  vacuum: permittivity=1
  copper: permeability=0.999991 conductivity=58000000
  Rogers RT/duroid 5880 (tm): permittivity=2.2 dielectric_loss_tangent=0.0009

design HFSSDesign1 (HFSS, DrivenModal, model units mm)
variables:
  s = 0.06mm
  rate = 250
  TL = 14mm
  sL = 5mm
  ext = 0.5mm
  cThick = 0.035mm
  subT = 1.57mm
  nudge = 3.5mm
  MW = 0.1mm
  QWM = 7.43mm
geometry:
  EquationSurface1 = equation_based_surface(XuvFunction=_u YuvFunction=s*_v*exp(_u*rate) ZuvFunction=0 uStart=0 uEnd=TL vStart=-1 vEnd=1)
  Rectangle1 = rectangle(corner=(-sL, -s, 0mm), x_size=sL, y_size=2*s)
  EquationSurface1.unite(Rectangle1)
  Rectangle2 [copper] = rectangle(corner=(-sL -ext, -TL/2, 0mm), x_size=TL+sL+ext, y_size=TL)
  Rectangle2.subtract(EquationSurface1)
  Rectangle2.thicken(cThick)
  Box1 [Rogers RT/duroid 5880 (tm)] = box(corner=(-sL-ext, -TL/2, -subT), size=(TL+sL+ext, TL, subT))
  Rectangle3 [copper] = rectangle(corner=(-sL-ext, nudge, -subT-cThick), x_size=sL+ext+MW/2, y_size=MW)
  Rectangle4 = rectangle(corner=(-MW/2, -QWM-s, -subT-cThick), x_size=MW, y_size=QWM+nudge+s)
  Rectangle3.unite(Rectangle4)
  Rectangle3.thicken(cThick)
  Rectangle5 = rectangle(corner=(-sL-ext, nudge, cThick), y_size=MW, z_size=-subT-2*cThick)
  RadiatingSurface [vacuum] = region(absolute_offset=10mm on all sides)
boundaries and excitations:
  Open1: Radiation Objects=RadiatingSurface
  1: Lumped Port Objects=Rectangle5 Modes{Mode1{IntLine{(-5.5, 3.55, -1.605) -> (-5.5, 3.55, 0.035)} CharImp=Zpi RenormImp=50ohm}} Impedance=50ohm
setups:
  Setup1: HfssDriven Frequency=10GHz MaxDeltaS=0.02 MaximumPasses=6 MinimumPasses=1 MinimumConvergedPasses=1 PercentRefinement=30 BasisOrder=1 PortAccuracy=2 DrivenSolverType="Direct Solver"
    sweep Sweep: 7GHz to 12GHz, 401 points; Type=Interpolating InterpTolerance=0.5 InterpMaxSolns=250 InterpUsePortImped=false PassivityErrorTolerance=0.0001
source amplitudes:
  1:1: 1W 0deg
radiation setups:
  3D: Infinite Sphere Theta=0deg..180deg step 2deg Phi=-180deg..180deg step 2deg
  Elevation: Infinite Sphere Theta=-180deg..180deg step 1deg Phi=0deg..90deg step 90deg
  Azimuth: Infinite Sphere Theta=90deg..90deg step 0deg Phi=-180deg..180deg step 1deg
reports:
  S Parameter Plot 1: dB(S(1,1)) vs Freq on Setup1 : Sweep
  Gain Plot 1: dB(GainTotal) vs Phi, Theta on Setup1 : LastAdaptive, 3D [Freq=10GHz]
  S Parameter Plot 2: dB(S(1,1)) vs Freq, s on Setup1 : Sweep
  S Parameter Plot 3: dB(S(1,1)) vs Freq, s on Setup1 : Sweep
  S Parameter Table 1: dB(S(1,1)) vs Freq on Setup1 : Sweep
